* NMOS Id–Vgs sweep (Sky130)

.lib "/home/oliviag/skywater130nm/volare/sky130/versions/a918dc7c8e474a99b68c85eb3546b4ed91fe9e7b/sky130A/libs.tech/ngspice/sky130.lib.spice" tt_77k

XM2 VDD gate GND GND sky130_fd_pr__nfet_01v8_lvt l=0.15 w=1.6 nf=1 ad='floor((nf+1)/2) * w/nf * 0.29' as='floor((nf+2)/2) * w/nf * 0.29' pd='2 * floor((nf+1)/2) * (w/nf + 0.29)' ps='2 * floor((nf+2)/2) * (w/nf + 0.29)' nrd='0.29 / w' nrs='0.29 / w' sa=0 sb=0 sd=0 mult=1 m=1
Vds VDD GND 1.48
Vgs gate GND 0

.temp -196.15

.control
set noaskquit
dc Vgs 0.0 1.85 0.01
let id_axis = -i(vds)
set curplottype=family
wrdata idvg_family.txt id_axis
.endc
.end
