* NMOS Id–Vgs sweep (Sky130)
.options scale=1.0
.options temp=-196.15
.options noacct noopalter

.lib "/home/oliviag/skywater130nm/volare/sky130/versions/a918dc7c8e474a99b68c85eb3546b4ed91fe9e7b/sky130A/libs.tech/ngspice/sky130.lib.spice" tt_77k

VDS DRAIN 0 1.85

VGS GATE 0 1.85

XM1 DRAIN GATE 0 0 sky130_fd_pr__nfet_01v8_lvt w=1.6u l=0.15u nf=1 ad=0.384p as=0.384p pd=2.08u ps=2.08u
