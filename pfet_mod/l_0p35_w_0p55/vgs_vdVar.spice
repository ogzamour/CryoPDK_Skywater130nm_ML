* PMOS Id–Vgs sweep (Sky130)
.options compatibility=hspice
.options kboltz=1.380649e-23 charge=1.60217663e-19
.options gmin=1e-15 abstol=1e-13 chgtol=1e-16 rtol=0.001
.options scale=1.0
.options tnom=-196.15
.options reltol=1e-5 abstol=1e-14 vntol=1e-7 gmin=1e-15
.options chgtol=1e-15 method=gear
.lib "/home/oliviag/skywater130nm/volare/sky130/versions/a918dc7c8e474a99b68c85eb3546b4ed91fe9e7b/sky130A/libs.tech/ngspice/sky130.lib.spice" tt_77k
.temp -196.15

*source
VDD SOURCE 0 0

* Drain-source bias
VDS DRAIN 0 0

* Gate-source bias
VGS GATE 0 0

* MOSFET
XM1 DRAIN GATE SOURCE SOURCE sky130_fd_pr__pfet_01v8_lvt w=0.55u l=0.35u
*nf=1 ad=0.384p as=0.384p pd=2.08u ps=2.08u

.control
set noaskquit
  destroy all
set filetype=ascii
showmod m.xm1.msky130_fd_pr__pfet_01v8_lvt : vth0 u0 rdsw nfactor vsat eta0 delta
altermod m.xm1.msky130_fd_pr__pfet_01v8_lvt tnoimod = 2
  compose vds_vals values 0.01 0.37 0.74 1.11 1.45 1.85

  foreach idx 0 1 2 3 4 5

    let current_vds = vds_vals[$idx]
    set vds_scalar = $&current_vds
    alter VDS = -$&current_vds

    save @m.xm1.msky130_fd_pr__pfet_01v8_lvt[id] v(GATE)

    dc VGS 0 -1.85 -0.01

    let vgs_axis = v(GATE)
    let id_axis = -@m.xm1.msky130_fd_pr__pfet_01v8_lvt[id]
    let vds_axis = current_vds

    wrdata /home/oliviag/ngspice-skywater-sims/pfet_mod/l_0p35_w_0p55/vg_sweep/p_vgs_sweep_step{$idx}.txt vgs_axis id_axis vds_axis

  end
.endc

.end
