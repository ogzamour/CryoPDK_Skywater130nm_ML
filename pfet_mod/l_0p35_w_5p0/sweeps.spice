* PMOS Id–Vgs sweep (Sky130)
*.options scale=1.0u

XM1 VDD gate GND GND sky130_fd_pr__pfet_01v8_lvt l=0.35 w=5 nf=1 ad='floor((nf+1)/2) * w/nf * 0.29' as='floor((nf+2)/2) * w/nf * 0.29' pd='2 * floor((nf+1)/2) * (w/nf + 0.29)' ps='2 * floor((nf+2)/2) * (w/nf + 0.29)' nrd='0.29 / w' nrs='0.29 / w' sa=0 sb=0 sd=0 mult=3 m=3
.lib "/home/oliviag/skywater130nm/volare/sky130/versions/a918dc7c8e474a99b68c85eb3546b4ed91fe9e7b/sky130A/libs.tech/ngspice/sky130.lib.spice" tt_77k

*XM1 GND gate VDD VDD sky130_fd_pr__pfet_01v8_lvt l=0.35 w=5 nf=1 ad='floor((nf+1)/2) * w/nf * 0.29' as='floor((nf+2)/2) * w/nf * 0.29' pd='2 * floor((nf+1)/2) * (w/nf + 0.29)' ps='2 * floor((nf+2)/2) * (w/nf + 0.29)' nrd='0.29 / w' nrs='0.29 / w' sa=0 sb=0 sd=0 mult=3 m=3
Vgs gate GND 0
*Vgs gate GND 0
Vds VDD GND 0
*-1.48
 *begin user architecture code

.temp -196.15

.control
  set noaskquit

*TRANSFER CHARACTERISTIC: Id vs Vgs (stepping Vds)
*save i(Vds) v(gate) v(vdd)

*rest
dc Vgs 0 -1.85 -0.01  Vds 0 -1.85 -0.185
showmod m.xm1.msky130_fd_pr__pfet_01v8_lvt : vth0 u0 rdsw nfactor vsat eta0 delta > ogparam.txt
*showmod M.XM1.msky130_fd_pr__pfet_01v8_lvt

  set curplottype=family
  *plot -i(Vds) vs v(gate)
    setplot
    display
    shell pwd
    let id_axis = -vds#branch
    *let id_axis = -i(vds)
    set raw_array = ( `cat ogparam.txt` )
    set vth_axis = $raw_array[11]
   wrdata vg_sweep/p_vgs_sweep_family.txt gate id_axis vdd
reset
dc Vgs 0 -1.85 -0.01  Vds -0.01 -0.011 -1

  set curplottype=family
  *plot -i(Vds) vs v(gate)
    setplot
    display
    shell pwd
    let idB = -vds#branch
    *let idB = -i(vds)
    set raw_array = ( `cat ogparam.txt` )
    set vth_axis = $raw_array[11]
   wrdata vg_sweep/idVg_vd_0p010.txt gate idB vdd
    *shell ls -l test.txt
*wrdata /home/oliviag/ngspice-skywater-sims/pfet_mod/l_0p35_w_1p6/vg_sweep/p_vgs_sweep_family.txt v(gate)  i(Vds) v(vdd)

* OUTPUT CHARACTERISTIC: Id vs Vds (stepping Vgs)
reset
  *save i(Vds) v(gate) v(vdd)
dc Vds 0 -1.85 -0.01  Vgs 0 -1.85 -0.185
    set curplottype=family
      setplot
      display
      shell pwd

  *plot -i(Vds) vs v(vdd)
      let ax_id = -vds#branch
    *let ax_id =  -i(vds)
    set raw_array = ( `cat ogparam.txt` )
    set vth_axis = $raw_array[11]
    wrdata vd_sweep/p_vds_sweep_family.txt v(gate) ax_id v(vdd)

  set filetype=csv
  *wrdata  /home/oliviag/ngspice-skywater-sims/pfet_mod/l_0p35_w_1p6/vd_sweep/p_vds_sweep_family.csv v(gate)  -i(Vds) v(vdd)
.endc

*.save all

* end user architecture code

*.GLOBAL GND
*.GLOBAL VDD
.end
