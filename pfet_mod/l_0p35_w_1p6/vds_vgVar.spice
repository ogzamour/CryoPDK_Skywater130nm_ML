* PMOS Id–Vgs sweep (Sky130)
.options compatibility=hspice
.options kboltz=1.380649e-23 charge=1.60217663e-19
.options gmin=1e-15 abstol=1e-13 chgtol=1e-16 rtol=0.001
.options scale=1.0
.options tnom=-196.15
*temp=-196.15
.options reltol=1e-5 abstol=1e-14 vntol=1e-7 gmin=1e-15
.options chgtol=1e-15 method=gear
.lib "/home/oliviag/skywater130nm/volare/sky130/versions/a918dc7c8e474a99b68c85eb3546b4ed91fe9e7b/sky130A/libs.tech/ngspice/sky130.lib.spice" tt_77k

*source
*VDD SOURCE 0 0

VGS GATE 0 0.01

VDS DRAIN 0 1.85

* MOSFET

XM1 DRAIN GATE 0 0 sky130_fd_pr__pfet_01v8_lvt w=0.55u l=0.35u
*nf=1 ad=0.384p as=0.384p pd=2.08u ps=2.08u

.control
  destroy all
set filetype=ascii
altermod m.xm1.msky130_fd_pr__pfet_01v8_lvt tnoimod = 2
showmod m.xm1.msky130_fd_pr__pfet_01v8_lvt : vth0 u0 rdsw nfactor vsat eta0 delta

  compose vgs_vals values 1.85 1.48 1.11 0.74 0.37

  foreach idx 0 1 2 3 4
    let current_vgs = vgs_vals[$idx]
    set vgs_scalar = $&current_vgs
    alter VGS = -$&current_vgs

    save v(DRAIN) v(GATE) @m.xm1.msky130_fd_pr__pfet_01v8_lvt[id]
    dc VDS 0 -1.85 -0.01
    let vds_axis{$idx} = v(DRAIN)
    let id_axis{$idx}  = -@m.xm1.msky130_fd_pr__pfet_01v8_lvt[id]
    let vgs_axis{$idx} = -current_vgs

    * Write the completely isolated vectors out
    wrdata /home/oliviag/ngspice-skywater-sims/pfet_mod/l_0p35_w_0p55/vd_sweep/p_vds_sweep_step{$idx}.txt vgs_axis{$idx} id_axis{$idx} vds_axis{$idx}

    *let vds_axis = v(DRAIN)
    *let id_axis = -@m.xm1.msky130_fd_pr__pfet_01v8_lvt[id]
    *let vgs_axis  = -current_vgs

    wrdata /home/oliviag/ngspice-skywater-sims/pfet_mod/l_0p35_w_1p6/vd_sweep/p_vds_sweep_step{$idx}.txt vgs_axis{$idx} id_axis{$idx} vds_axis{$idx}

  end
.endc

.end
