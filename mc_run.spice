* NMOS Id–Vgs sweep (Sky130)
.options scale=1.0
.options temp=-196.15
.options noacct noopalter

.lib "/home/oliviag/skywater130nm/volare/sky130/versions/a918dc7c8e474a99b68c85eb3546b4ed91fe9e7b/sky130A/libs.tech/ngspice/sky130.lib.spice" tt_77k

VDS DRAIN 0 0

VGS GATE 0 1.85

XM1 DRAIN GATE 0 0 sky130_fd_pr__nfet_01v8_lvt w=1.6u l=0.15u nf=1 ad=0.384p as=0.384p pd=2.08u ps=2.08u

        .control
        run
        set filetype=ascii
        *showmod m.xm1.msky130_fd_pr__nfet_01v8_lvt : vth0 u0 rdsw nfactor vsat eta0 delta

        *running montecarlo sim, 1 param at at a time
        showmod m.xm1.msky130_fd_pr__nfet_01v8_lvt : vth0 u0 rdsw nfactor vsat eta0 delta > ogparam.txt
        set raw_array = ( `cat ogparam.txt` )
          define agauss(mean, sigma) (mean + sigma * sgauss(0))
          set nom_vth0 = $raw_array[11]
          set nom_u0 = $raw_array[13]
          set nom_rdsw = $raw_array[15]
          set nom_nfactor = $raw_array[17]
          set nom_vsat = $raw_array[19]
          set nom_eta0 = $raw_array[21]
          set nom_delta = $raw_array[23]
        *showmod m.xm1.msky130_fd_pr__nfet_01v8_lvt : vth0 u0 rdsw nfactor vsat eta0 delta
        *echo "$nom_vth0"
        set outDir = /home/oliviag/ngspice-skywater-sims/mc_vds_output/2026-06-12_20-35-51
        *controls
          let mc_vth0 = 1
          let mc_u0 = 1
          let mc_rdsw = 1
          let mc_nfactor = 1
          let mc_vsat = 1
          let mc_eta0 = 1
          let mc_delta = 1
        let i_max = 10000
        let idx = 0
        let i1 = 1

      let s_vth0 = 0.319943
      let s_u0 = 0.0430804
      let s_rdsw = 103.65
      let s_nfactor = 0.0351348
      let s_vsat = 78424.2
      let s_eta0 = -0.191127
      let s_delta = 0.01

dowhile (idx < i_max)

    *echo "========================================="
    echo " MONTE CARLO RUN: $&idx"
    *echo "========================================="
    let v_vth0 = $nom_vth0
    let v_u0 = $nom_u0
    let v_rdsw = $nom_rdsw
    let v_nfactor = $nom_nfactor
    let v_vsat = $nom_vsat
    let v_eta0 = $nom_eta0
    let v_delta = $nom_delta

    let vth0_min = 0.9 * s_vth0
    let vth0_max = 1.1 * $nom_vth0
    let u0_min = 0.9 * s_u0
    let u0_max = 1.1 * $nom_u0
    let rdsw_min = 0.9 * s_rdsw
    let rdsw_max = 1.1 * $nom_rdsw
    let nf_min = 0.9 * s_nfactor
    let nf_max = 1.1 * $nom_nfactor
    let vsat_min = 0.9 * s_vsat
    let vsat_max = 1.1 * $nom_vsat
    let eta0_min = 0.9 * s_eta0
    let eta0_max = 1.1 * $nom_eta0
    let delta_min = 0.9 * s_delta
    let delta_max = 1.1 * $nom_delta
    print idx

    let u = agauss(0,1)
    let u = (u + 3) / 6
    let u = (u > 1)*1 + (u <= 1)*((u < 0) * 0 + (u >= 0) * u)

    if (mc_vth0)
      *let v_vth0 = agauss($nom_vth0, $s_vth0)
      let v_vth0 = {vth0_min} + ({vth0_max} - {vth0_min}) * u
      *echo $&v_vth0
    endif
    if (mc_u0)
      *let v_u0 = agauss($nom_u0, $s_u0)
      let v_u0 = {u0_min} + ({u0_max} - {u0_min}) * u
    endif
    if (mc_rdsw)
      *let v_rdsw = agauss($nom_rdsw, $s_rdsw)
      let v_rdsw = {rdsw_min} + ({rdsw_max} - {rdsw_min}) * u
    endif
    if (mc_nfactor)
      *let v_nfactor = agauss($nom_nfactor, $s_nfactor)
      let v_nfactor = {nf_min} + ({nf_max} - {nf_min}) * u
    endif
    if (mc_vsat)
      *let v_vsat = agauss($nom_vsat, $s_vsat)
      let v_vsat = {vsat_min} + ({vsat_max} - {vsat_min}) * u
    endif
    if (mc_eta0)
      *let v_eta0 = agauss($nom_eta0, $s_eta0)
      let v_eta0 = {eta0_min} + ({eta0_max} - {eta0_min}) * u
    endif
    if (mc_delta)
      *let v_delta = agauss($nom_delta, $s_delta)
      let v_delta = {delta_min} + ({delta_max} - {delta_min}) * u
    endif

    *showmod m.xm1.msky130_fd_pr__nfet_01v8_lvt : vth0 u0 rdsw nfactor vsat eta0 delta
    altermod @m.xm1.msky130_fd_pr__nfet_01v8_lvt[vth0]    = $&v_vth0
    altermod @m.xm1.msky130_fd_pr__nfet_01v8_lvt[u0]      = $&v_u0
    altermod @m.xm1.msky130_fd_pr__nfet_01v8_lvt[rdsw]    = $&v_rdsw
    altermod @m.xm1.msky130_fd_pr__nfet_01v8_lvt[nfactor] = $&v_nfactor
    altermod @m.xm1.msky130_fd_pr__nfet_01v8_lvt[vsat]    = $&v_vsat
    altermod @m.xm1.msky130_fd_pr__nfet_01v8_lvt[eta0]    = $&v_eta0
    altermod @m.xm1.msky130_fd_pr__nfet_01v8_lvt[delta]   = $&v_delta

    *showmod m.xm1.msky130_fd_pr__nfet_01v8_lvt : vth0 u0 rdsw nfactor vsat eta0 delta
    dc VDS 0 1.85 0.01

    let out_vth0    = v_vth0*(v(drain)*0 + 1)
    let out_u0      = v_u0 * (v(DRAIN)*0 + 1)
    let out_rdsw    = v_rdsw * (v(DRAIN)*0 + 1)
    let out_nfactor = v_nfactor * (v(DRAIN)*0 + 1)
    let out_vsat    = v_vsat * (v(DRAIN)*0 + 1)
    let out_eta0    = v_eta0 * (v(DRAIN)*0 + 1)
    let out_delta   = v_delta * (v(DRAIN)*0 + 1)
    let run_num     = $&idx * (v(DRAIN)*0 + 1)

    set wr_vecnames
    set wr_singlescale

    *set raw_file = "mc_output/output{$&idx}.dat"
    set raw_file = "$outDir/output{$&idx}.dat"
    wrdata $raw_file run_num v(gate) i(vds) out_vth0 out_u0 out_rdsw out_nfactor out_vsat out_eta0
    *let hold = idx
    let idx = idx + i1

  end

quit
.endc

.end
