* NMOS sweep (Sky130)

XM1 VDD gate GND GND sky130_fd_pr__nfet_01v8_lvt l=0.15 w=1.6 nf=1 ad='floor((nf+1)/2) * w/nf * 0.29' as='floor((nf+2)/2) * w/nf * 0.29' pd='2 * floor((nf+1)/2) * (w/nf + 0.29)' ps='2 * floor((nf+2)/2) * (w/nf + 0.29)' nrd='0.29 / w' nrs='0.29 / w' sa=0 sb=0 sd=0 mult=1 m=1
.lib "/home/oliviag/skywater130nm/volare/sky130/versions/a918dc7c8e474a99b68c85eb3546b4ed91fe9e7b/sky130A/libs.tech/ngspice/sky130.lib.spice" tt_77k

Vgs gate GND 0
Vds VDD GND 1.48
.temp -196.15

.control
set noaskquit
set filetype=ascii
run
echo " MONTE CARLO RUN: 0"
set outDir = /home/oliviag/ngspice-skywater-sims/montecarlo/mc_output_lhc/nmos_FET_len_0p15_wid_1p6/data_2026-06-29_16-47-04/run_0
altermod @m.xm1.msky130_fd_pr__nfet_01v8_lvt[vth0]    = 0.3768012213305179
altermod @m.xm1.msky130_fd_pr__nfet_01v8_lvt[u0]      = 0.07434387025650072
altermod @m.xm1.msky130_fd_pr__nfet_01v8_lvt[rdsw]    = 103.61042769759524
altermod @m.xm1.msky130_fd_pr__nfet_01v8_lvt[nfactor] = 11.453913913082106
altermod @m.xm1.msky130_fd_pr__nfet_01v8_lvt[vsat]    = 143172.62393559294
altermod @m.xm1.msky130_fd_pr__nfet_01v8_lvt[eta0]    = -0.19270912340942253
altermod @m.xm1.msky130_fd_pr__nfet_01v8_lvt[delta]   = 0.0510505265047999
dc Vds 0 1.85 0.01 Vgs 0 1.85 0.185
let out_vth0    = 0.3768012213305179 * (v(gate)*0 + 1)
let out_u0      = 0.07434387025650072 * (v(gate)*0 + 1)
let out_rdsw    = 103.61042769759524 * (v(gate)*0 + 1)
let out_nfactor = 11.453913913082106 * (v(gate)*0 + 1)
let out_vsat    = 143172.62393559294 * (v(gate)*0 + 1)
let out_eta0    = -0.19270912340942253 * (v(gate)*0 + 1)
let out_delta   = 0.0510505265047999 * (v(gate)*0 + 1)
let run_num     = 0 * (v(gate)*0 + 1)
let ax_id0 = -vds#branch
set raw_file = "$outDir/vds_sweep.txt"
set wr_vecnames
set wr_singlescale
wrdata $raw_file vdd gate ax_id0 out_vth0 out_u0 out_rdsw out_nfactor out_vsat out_eta0
dc Vgs 0 1.85 0.01 Vds 0.01 0.01 1
let out_vth0    = 0.3768012213305179 * (v(gate)*0 + 1)
let out_u0      = 0.07434387025650072 * (v(gate)*0 + 1)
let out_rdsw    = 103.61042769759524 * (v(gate)*0 + 1)
let out_nfactor = 11.453913913082106 * (v(gate)*0 + 1)
let out_vsat    = 143172.62393559294 * (v(gate)*0 + 1)
let out_eta0    = -0.19270912340942253 * (v(gate)*0 + 1)
let out_delta   = 0.0510505265047999 * (v(gate)*0 + 1)
let run_num     = 0 * (v(gate)*0 + 1)
let ax_id1 = -vds#branch
set raw_file = "$outDir/vgs_0p01_sweep.txt"
wrdata $raw_file vdd gate ax_id1 out_vth0 out_u0 out_rdsw out_nfactor out_vsat out_eta0
dc Vgs 0 1.85 0.01 Vds 0 1.85 0.185
let out_vth0    = 0.3768012213305179 * (v(gate)*0 + 1)
let out_u0      = 0.07434387025650072 * (v(gate)*0 + 1)
let out_rdsw    = 103.61042769759524 * (v(gate)*0 + 1)
let out_nfactor = 11.453913913082106 * (v(gate)*0 + 1)
let out_vsat    = 143172.62393559294 * (v(gate)*0 + 1)
let out_eta0    = -0.19270912340942253 * (v(gate)*0 + 1)
let out_delta   = 0.0510505265047999 * (v(gate)*0 + 1)
let run_num     = 0 * (v(gate)*0 + 1)
let ax_id2 = -vds#branch
set raw_file = "$outDir/vgs_sweep.txt"
wrdata $raw_file vdd gate ax_id2 out_vth0 out_u0 out_rdsw out_nfactor out_vsat out_eta0
reset
echo " MONTE CARLO RUN: 1"
set outDir = /home/oliviag/ngspice-skywater-sims/montecarlo/mc_output_lhc/nmos_FET_len_0p15_wid_1p6/data_2026-06-29_16-47-04/run_1
altermod @m.xm1.msky130_fd_pr__nfet_01v8_lvt[vth0]    = 0.4007559982467983
altermod @m.xm1.msky130_fd_pr__nfet_01v8_lvt[u0]      = 0.07049802456247198
altermod @m.xm1.msky130_fd_pr__nfet_01v8_lvt[rdsw]    = 95.57279532430985
altermod @m.xm1.msky130_fd_pr__nfet_01v8_lvt[nfactor] = 10.91721060083692
altermod @m.xm1.msky130_fd_pr__nfet_01v8_lvt[vsat]    = 133592.17618790167
altermod @m.xm1.msky130_fd_pr__nfet_01v8_lvt[eta0]    = -0.18270017485664514
altermod @m.xm1.msky130_fd_pr__nfet_01v8_lvt[delta]   = 0.0487357198144283
dc Vds 0 1.85 0.01 Vgs 0 1.85 0.185
let out_vth0    = 0.4007559982467983 * (v(gate)*0 + 1)
let out_u0      = 0.07049802456247198 * (v(gate)*0 + 1)
let out_rdsw    = 95.57279532430985 * (v(gate)*0 + 1)
let out_nfactor = 10.91721060083692 * (v(gate)*0 + 1)
let out_vsat    = 133592.17618790167 * (v(gate)*0 + 1)
let out_eta0    = -0.18270017485664514 * (v(gate)*0 + 1)
let out_delta   = 0.0487357198144283 * (v(gate)*0 + 1)
let run_num     = 1 * (v(gate)*0 + 1)
let ax_id0 = -vds#branch
set raw_file = "$outDir/vds_sweep.txt"
set wr_vecnames
set wr_singlescale
wrdata $raw_file vdd gate ax_id0 out_vth0 out_u0 out_rdsw out_nfactor out_vsat out_eta0
dc Vgs 0 1.85 0.01 Vds 0.01 0.01 1
let out_vth0    = 0.4007559982467983 * (v(gate)*0 + 1)
let out_u0      = 0.07049802456247198 * (v(gate)*0 + 1)
let out_rdsw    = 95.57279532430985 * (v(gate)*0 + 1)
let out_nfactor = 10.91721060083692 * (v(gate)*0 + 1)
let out_vsat    = 133592.17618790167 * (v(gate)*0 + 1)
let out_eta0    = -0.18270017485664514 * (v(gate)*0 + 1)
let out_delta   = 0.0487357198144283 * (v(gate)*0 + 1)
let run_num     = 1 * (v(gate)*0 + 1)
let ax_id1 = -vds#branch
set raw_file = "$outDir/vgs_0p01_sweep.txt"
wrdata $raw_file vdd gate ax_id1 out_vth0 out_u0 out_rdsw out_nfactor out_vsat out_eta0
dc Vgs 0 1.85 0.01 Vds 0 1.85 0.185
let out_vth0    = 0.4007559982467983 * (v(gate)*0 + 1)
let out_u0      = 0.07049802456247198 * (v(gate)*0 + 1)
let out_rdsw    = 95.57279532430985 * (v(gate)*0 + 1)
let out_nfactor = 10.91721060083692 * (v(gate)*0 + 1)
let out_vsat    = 133592.17618790167 * (v(gate)*0 + 1)
let out_eta0    = -0.18270017485664514 * (v(gate)*0 + 1)
let out_delta   = 0.0487357198144283 * (v(gate)*0 + 1)
let run_num     = 1 * (v(gate)*0 + 1)
let ax_id2 = -vds#branch
set raw_file = "$outDir/vgs_sweep.txt"
wrdata $raw_file vdd gate ax_id2 out_vth0 out_u0 out_rdsw out_nfactor out_vsat out_eta0
reset
echo " MONTE CARLO RUN: 2"
set outDir = /home/oliviag/ngspice-skywater-sims/montecarlo/mc_output_lhc/nmos_FET_len_0p15_wid_1p6/data_2026-06-29_16-47-04/run_2
altermod @m.xm1.msky130_fd_pr__nfet_01v8_lvt[vth0]    = 0.4466404139564917
altermod @m.xm1.msky130_fd_pr__nfet_01v8_lvt[u0]      = 0.07590159476076472
altermod @m.xm1.msky130_fd_pr__nfet_01v8_lvt[rdsw]    = 109.44608918375636
altermod @m.xm1.msky130_fd_pr__nfet_01v8_lvt[nfactor] = 10.513000588763353
altermod @m.xm1.msky130_fd_pr__nfet_01v8_lvt[vsat]    = 146528.15758318323
altermod @m.xm1.msky130_fd_pr__nfet_01v8_lvt[eta0]    = -0.20173479865936053
altermod @m.xm1.msky130_fd_pr__nfet_01v8_lvt[delta]   = 0.05333498149031086
dc Vds 0 1.85 0.01 Vgs 0 1.85 0.185
let out_vth0    = 0.4466404139564917 * (v(gate)*0 + 1)
let out_u0      = 0.07590159476076472 * (v(gate)*0 + 1)
let out_rdsw    = 109.44608918375636 * (v(gate)*0 + 1)
let out_nfactor = 10.513000588763353 * (v(gate)*0 + 1)
let out_vsat    = 146528.15758318323 * (v(gate)*0 + 1)
let out_eta0    = -0.20173479865936053 * (v(gate)*0 + 1)
let out_delta   = 0.05333498149031086 * (v(gate)*0 + 1)
let run_num     = 2 * (v(gate)*0 + 1)
let ax_id0 = -vds#branch
set raw_file = "$outDir/vds_sweep.txt"
set wr_vecnames
set wr_singlescale
wrdata $raw_file vdd gate ax_id0 out_vth0 out_u0 out_rdsw out_nfactor out_vsat out_eta0
dc Vgs 0 1.85 0.01 Vds 0.01 0.01 1
let out_vth0    = 0.4466404139564917 * (v(gate)*0 + 1)
let out_u0      = 0.07590159476076472 * (v(gate)*0 + 1)
let out_rdsw    = 109.44608918375636 * (v(gate)*0 + 1)
let out_nfactor = 10.513000588763353 * (v(gate)*0 + 1)
let out_vsat    = 146528.15758318323 * (v(gate)*0 + 1)
let out_eta0    = -0.20173479865936053 * (v(gate)*0 + 1)
let out_delta   = 0.05333498149031086 * (v(gate)*0 + 1)
let run_num     = 2 * (v(gate)*0 + 1)
let ax_id1 = -vds#branch
set raw_file = "$outDir/vgs_0p01_sweep.txt"
wrdata $raw_file vdd gate ax_id1 out_vth0 out_u0 out_rdsw out_nfactor out_vsat out_eta0
dc Vgs 0 1.85 0.01 Vds 0 1.85 0.185
let out_vth0    = 0.4466404139564917 * (v(gate)*0 + 1)
let out_u0      = 0.07590159476076472 * (v(gate)*0 + 1)
let out_rdsw    = 109.44608918375636 * (v(gate)*0 + 1)
let out_nfactor = 10.513000588763353 * (v(gate)*0 + 1)
let out_vsat    = 146528.15758318323 * (v(gate)*0 + 1)
let out_eta0    = -0.20173479865936053 * (v(gate)*0 + 1)
let out_delta   = 0.05333498149031086 * (v(gate)*0 + 1)
let run_num     = 2 * (v(gate)*0 + 1)
let ax_id2 = -vds#branch
set raw_file = "$outDir/vgs_sweep.txt"
wrdata $raw_file vdd gate ax_id2 out_vth0 out_u0 out_rdsw out_nfactor out_vsat out_eta0
reset
echo " MONTE CARLO RUN: 3"
set outDir = /home/oliviag/ngspice-skywater-sims/montecarlo/mc_output_lhc/nmos_FET_len_0p15_wid_1p6/data_2026-06-29_16-47-04/run_3
altermod @m.xm1.msky130_fd_pr__nfet_01v8_lvt[vth0]    = 0.42825491719347686
altermod @m.xm1.msky130_fd_pr__nfet_01v8_lvt[u0]      = 0.0681812418119075
altermod @m.xm1.msky130_fd_pr__nfet_01v8_lvt[rdsw]    = 102.1825556134669
altermod @m.xm1.msky130_fd_pr__nfet_01v8_lvt[nfactor] = 12.232120347494853
altermod @m.xm1.msky130_fd_pr__nfet_01v8_lvt[vsat]    = 127541.90941923947
altermod @m.xm1.msky130_fd_pr__nfet_01v8_lvt[eta0]    = -0.1779114286990891
altermod @m.xm1.msky130_fd_pr__nfet_01v8_lvt[delta]   = 0.05485684533810834
dc Vds 0 1.85 0.01 Vgs 0 1.85 0.185
let out_vth0    = 0.42825491719347686 * (v(gate)*0 + 1)
let out_u0      = 0.0681812418119075 * (v(gate)*0 + 1)
let out_rdsw    = 102.1825556134669 * (v(gate)*0 + 1)
let out_nfactor = 12.232120347494853 * (v(gate)*0 + 1)
let out_vsat    = 127541.90941923947 * (v(gate)*0 + 1)
let out_eta0    = -0.1779114286990891 * (v(gate)*0 + 1)
let out_delta   = 0.05485684533810834 * (v(gate)*0 + 1)
let run_num     = 3 * (v(gate)*0 + 1)
let ax_id0 = -vds#branch
set raw_file = "$outDir/vds_sweep.txt"
set wr_vecnames
set wr_singlescale
wrdata $raw_file vdd gate ax_id0 out_vth0 out_u0 out_rdsw out_nfactor out_vsat out_eta0
dc Vgs 0 1.85 0.01 Vds 0.01 0.01 1
let out_vth0    = 0.42825491719347686 * (v(gate)*0 + 1)
let out_u0      = 0.0681812418119075 * (v(gate)*0 + 1)
let out_rdsw    = 102.1825556134669 * (v(gate)*0 + 1)
let out_nfactor = 12.232120347494853 * (v(gate)*0 + 1)
let out_vsat    = 127541.90941923947 * (v(gate)*0 + 1)
let out_eta0    = -0.1779114286990891 * (v(gate)*0 + 1)
let out_delta   = 0.05485684533810834 * (v(gate)*0 + 1)
let run_num     = 3 * (v(gate)*0 + 1)
let ax_id1 = -vds#branch
set raw_file = "$outDir/vgs_0p01_sweep.txt"
wrdata $raw_file vdd gate ax_id1 out_vth0 out_u0 out_rdsw out_nfactor out_vsat out_eta0
dc Vgs 0 1.85 0.01 Vds 0 1.85 0.185
let out_vth0    = 0.42825491719347686 * (v(gate)*0 + 1)
let out_u0      = 0.0681812418119075 * (v(gate)*0 + 1)
let out_rdsw    = 102.1825556134669 * (v(gate)*0 + 1)
let out_nfactor = 12.232120347494853 * (v(gate)*0 + 1)
let out_vsat    = 127541.90941923947 * (v(gate)*0 + 1)
let out_eta0    = -0.1779114286990891 * (v(gate)*0 + 1)
let out_delta   = 0.05485684533810834 * (v(gate)*0 + 1)
let run_num     = 3 * (v(gate)*0 + 1)
let ax_id2 = -vds#branch
set raw_file = "$outDir/vgs_sweep.txt"
wrdata $raw_file vdd gate ax_id2 out_vth0 out_u0 out_rdsw out_nfactor out_vsat out_eta0
reset
echo " MONTE CARLO RUN: 4"
set outDir = /home/oliviag/ngspice-skywater-sims/montecarlo/mc_output_lhc/nmos_FET_len_0p15_wid_1p6/data_2026-06-29_16-47-04/run_4
altermod @m.xm1.msky130_fd_pr__nfet_01v8_lvt[vth0]    = 0.4110243293446675
altermod @m.xm1.msky130_fd_pr__nfet_01v8_lvt[u0]      = 0.08021139038897462
altermod @m.xm1.msky130_fd_pr__nfet_01v8_lvt[rdsw]    = 91.71858684312652
altermod @m.xm1.msky130_fd_pr__nfet_01v8_lvt[nfactor] = 11.950164343835914
altermod @m.xm1.msky130_fd_pr__nfet_01v8_lvt[vsat]    = 135351.5592249417
altermod @m.xm1.msky130_fd_pr__nfet_01v8_lvt[eta0]    = -0.20769125842530597
altermod @m.xm1.msky130_fd_pr__nfet_01v8_lvt[delta]   = 0.05759278032881253
dc Vds 0 1.85 0.01 Vgs 0 1.85 0.185
let out_vth0    = 0.4110243293446675 * (v(gate)*0 + 1)
let out_u0      = 0.08021139038897462 * (v(gate)*0 + 1)
let out_rdsw    = 91.71858684312652 * (v(gate)*0 + 1)
let out_nfactor = 11.950164343835914 * (v(gate)*0 + 1)
let out_vsat    = 135351.5592249417 * (v(gate)*0 + 1)
let out_eta0    = -0.20769125842530597 * (v(gate)*0 + 1)
let out_delta   = 0.05759278032881253 * (v(gate)*0 + 1)
let run_num     = 4 * (v(gate)*0 + 1)
let ax_id0 = -vds#branch
set raw_file = "$outDir/vds_sweep.txt"
set wr_vecnames
set wr_singlescale
wrdata $raw_file vdd gate ax_id0 out_vth0 out_u0 out_rdsw out_nfactor out_vsat out_eta0
dc Vgs 0 1.85 0.01 Vds 0.01 0.01 1
let out_vth0    = 0.4110243293446675 * (v(gate)*0 + 1)
let out_u0      = 0.08021139038897462 * (v(gate)*0 + 1)
let out_rdsw    = 91.71858684312652 * (v(gate)*0 + 1)
let out_nfactor = 11.950164343835914 * (v(gate)*0 + 1)
let out_vsat    = 135351.5592249417 * (v(gate)*0 + 1)
let out_eta0    = -0.20769125842530597 * (v(gate)*0 + 1)
let out_delta   = 0.05759278032881253 * (v(gate)*0 + 1)
let run_num     = 4 * (v(gate)*0 + 1)
let ax_id1 = -vds#branch
set raw_file = "$outDir/vgs_0p01_sweep.txt"
wrdata $raw_file vdd gate ax_id1 out_vth0 out_u0 out_rdsw out_nfactor out_vsat out_eta0
dc Vgs 0 1.85 0.01 Vds 0 1.85 0.185
let out_vth0    = 0.4110243293446675 * (v(gate)*0 + 1)
let out_u0      = 0.08021139038897462 * (v(gate)*0 + 1)
let out_rdsw    = 91.71858684312652 * (v(gate)*0 + 1)
let out_nfactor = 11.950164343835914 * (v(gate)*0 + 1)
let out_vsat    = 135351.5592249417 * (v(gate)*0 + 1)
let out_eta0    = -0.20769125842530597 * (v(gate)*0 + 1)
let out_delta   = 0.05759278032881253 * (v(gate)*0 + 1)
let run_num     = 4 * (v(gate)*0 + 1)
let ax_id2 = -vds#branch
set raw_file = "$outDir/vgs_sweep.txt"
wrdata $raw_file vdd gate ax_id2 out_vth0 out_u0 out_rdsw out_nfactor out_vsat out_eta0
reset
quit
.endc
.end
